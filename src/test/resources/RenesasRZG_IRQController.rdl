addrmap RenesasRZG_IRQController {

addrmap {
    desc = "Generated by RenodeModelsAnalyzer";
    reg {
        name="NonMaskableInterruptStatusControl";
        regwidth=0x20;
            field {
                desc = "The field is a Tag.";
                sw = rw;
            } NSTAT[0:0];
            field {
                desc = "The field is a Tag.";
                sw = rw;
            } NSMON[16:16];
    } NonMaskableInterruptStatusControl @ 0x0;
    reg {
        name="NonMaskableInterruptTypeSelection";
        regwidth=0x20;
            field {
                desc = "The field is a Tag.";
                sw = rw;
            } NSEL[0:0];
    } NonMaskableInterruptTypeSelection @ 0x4;
    external reg {
        name="InterruptStatusControl";
        regwidth=0x20;
            field {
                desc = "This field uses access mode that cannot be resolved at compile-time. This field has the following custom Renode callbacks: Write.";
                sw = rw;
                onwrite = wuser;
                onread = ruser;
            } ISTAT[7:0];
    } InterruptStatusControl @ 0x10;
    reg {
        name="InterruptTypeSelection";
        regwidth=0x20;
            field {
                sw = rw;
            } IISEL[7:0];
    } InterruptTypeSelection @ 0x14;
    external reg {
        name="GpioInterruptStatusControl";
        regwidth=0x20;
            field {
                desc = "This field uses access mode that cannot be resolved at compile-time. This field has the following custom Renode callbacks: Write.";
                sw = rw;
                onwrite = wuser;
                onread = ruser;
            } TSTAT[31:0];
    } GpioInterruptStatusControl @ 0x20;
    reg {
        name="GpioInterruptTypeSelection0";
        desc = "This register has the following custom Renode callbacks: Write";
        regwidth=0x20;
            field {
                sw = rw;
            } TITSEL[15:0];
    } GpioInterruptTypeSelection0 @ 0x24;
    reg {
        name="GpioInterruptTypeSelection1";
        desc = "This register has the following custom Renode callbacks: Write";
        regwidth=0x20;
            field {
                sw = rw;
            } TITSEL[15:0];
    } GpioInterruptTypeSelection1 @ 0x28;
    reg {
        name="GpioInterruptSourceSelection0";
        regwidth=0x20;
            field {
                desc = "This is a dummy r/w field, generated just to show the register in specs";
                sw = rw;
            } DUMMY[31:0];
    } GpioInterruptSourceSelection0 [8]@ 0x30 += 4;
    reg {
        name="BusErrorInterruptStatusControl0";
        regwidth=0x20;
            field {
                desc = "The field is a Tag.";
                sw = rw;
            } BESTA[31:0];
    } BusErrorInterruptStatusControl0 @ 0x50;
    reg {
        name="BusErrorInterruptStatusControl1";
        regwidth=0x20;
            field {
                desc = "The field is a Tag.";
                sw = rw;
            } BESTA[12:0];
    } BusErrorInterruptStatusControl1 @ 0x54;
    reg {
        name="EccRamErrorInterruptStatusControl0";
        regwidth=0x20;
            field {
                desc = "The field is a Tag.";
                sw = rw;
            } E1STAT[7:0];
            field {
                desc = "The field is a Tag.";
                sw = rw;
            } E2STAT[15:8];
            field {
                desc = "The field is a Tag.";
                sw = rw;
            } OFSTAT[23:16];
    } EccRamErrorInterruptStatusControl0 @ 0x60;
    reg {
        name="EccRamErrorInterruptStatusControl1";
        regwidth=0x20;
            field {
                desc = "The field is a Tag.";
                sw = rw;
            } E1STAT[7:0];
            field {
                desc = "The field is a Tag.";
                sw = rw;
            } E2STAT[15:8];
            field {
                desc = "The field is a Tag.";
                sw = rw;
            } OFSTAT[23:16];
    } EccRamErrorInterruptStatusControl1 @ 0x64;
} Registers_addrmap;


};