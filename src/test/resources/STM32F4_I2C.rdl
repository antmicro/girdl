addrmap STM32F4_I2C {

addrmap {
    desc = "Generated by RenodeModelsAnalyzer";
    reg {
        name="Control1";
        regwidth=0x20;
            field {
                sw = rw;
            } No_name_1[10:10];
            field {
                desc = "This field has the following custom Renode callbacks: Write.";
                sw = rw;
            } PeriEn[0:0];
            field {
                desc = "This field has the following custom Renode callbacks: Write.";
                sw = r;
            } StartGen[8:8];
            field {
                desc = "This field has the following custom Renode callbacks: Write.";
                sw = r;
            } StopGen[9:9];
            field {
                desc = "This field has the following custom Renode callbacks: Write.";
                sw = rw;
            } SWRST[15:15];
    } Control1 @ 0x0;
    reg {
        name="Control2";
        regwidth=0x20;
            field {
                desc = "This field has the following custom Renode callbacks: Change.";
                sw = rw;
            } No_name_4[10:10];
            field {
                sw = rw;
            } Freq[5:0];
            field {
                desc = "This field has the following custom Renode callbacks: Change.";
                sw = rw;
            } No_name_2_[9:9];
            field {
                sw = rw;
            } No_name_3_[8:8];
    } Control2 @ 0x4;
    reg {
        name="OwnAddress1";
        regwidth=0x20;
            field {
                desc = "This is a dummy r/w field, generated just to show the register in specs";
                sw = rw;
            } DUMMY[31:0];
    } OwnAddress1 @ 0x8;
    reg {
        name="OwnAddress2";
        regwidth=0x20;
            field {
                desc = "This is a dummy r/w field, generated just to show the register in specs";
                sw = rw;
            } DUMMY[31:0];
    } OwnAddress2 @ 0xc;
    reg {
        name="Data";
        regwidth=0x20;
            field {
                desc = "This field has the following custom Renode callbacks: Write, Provider.";
                sw = rw;
            } No_name_5[7:0];
    } Data @ 0x10;
    reg {
        name="Status1";
        regwidth=0x20;
            field {
                desc = "This field has the following custom Renode callbacks: Change.";
                sw = rw;
                onwrite = wzc;
                onread = rclr;
            } No_name_11[10:10];
            field {
                sw = r;
            } No_name_6_[7:7];
            field {
                desc = "This field has the following custom Renode callbacks: Provider.";
                sw = r;
            } No_name_7_[6:6];
            field {
                sw = r;
            } No_name_8_[2:2];
            field {
                sw = r;
            } No_name_9_[1:1];
            field {
                sw = r;
            } No_name_10_[0:0];
    } Status1 @ 0x14;
    reg {
        name="Status2";
        regwidth=0x20;
            field {
                sw = r;
            } No_name_13[2:2];
            field {
                desc = "This field has the following custom Renode callbacks: Read.";
                sw = r;
            } No_name_12_[0:0];
    } Status2 @ 0x18;
    reg {
        name="ClockControl";
        regwidth=0x20;
            field {
                desc = "This is a dummy r/w field, generated just to show the register in specs";
                sw = rw;
            } DUMMY[31:0];
    } ClockControl @ 0x1c;
    reg {
        name="RiseTime";
        regwidth=0x20;
            field {
                desc = "This is a dummy r/w field, generated just to show the register in specs";
                sw = rw;
                reset=32'b10;
            } DUMMY[31:0];
    } RiseTime @ 0x20;
    reg {
        name="NoiseFilter";
        regwidth=0x20;
            field {
                desc = "This is a dummy r/w field, generated just to show the register in specs";
                sw = rw;
            } DUMMY[31:0];
    } NoiseFilter @ 0x24;
} Registers_addrmap;


};