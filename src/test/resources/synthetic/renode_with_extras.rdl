addrmap FT5336 {

    reg Shared #(boolean SHARED) {
        shared = SHARED;
        B b;
        myBitFieldEncoding bfe;
    };

    struct A {
        longint v;
    };

    struct B {
        A a;
    };

    enum myBitFieldEncoding {
        first_encoding_entry = 8'hab;
        second_entry = 8'hcd {
            name = "second entry";
        };
        third_entry = 8'hef {
            name = "third entry, just like others";
            desc = "this value has a special documentation";
        };
        fourth_entry = 8'b10010011;
    };

    addrmap Regs {
        desc = "Generated by RenodeModelsAnalyzer";
        Shared #(.SHARED(true)) shared;
        reg {
            name="TouchXHigh";
            desc = "Could not determine register's width, guessed 8 bits.";
            regwidth=0x8;
                field {
                    desc = "This is a dummy r/w field, generated just to show the register in specs";
                    sw = rw;
                } DUMMY[7:0];
        } TouchXHigh @ 0x0;
        reg {
            name="TouchXLow";
            desc = "Could not determine register's width, guessed 8 bits.";
            regwidth=0x8;
                field {
                    desc = "This is a dummy r/w field, generated just to show the register in specs";
                    sw = rw;
                } DUMMY[7:0];
        } TouchXLow @ 0x1;
        reg {
            name="TouchYHigh";
            desc = "Could not determine register's width, guessed 8 bits.";
            regwidth=0x8;
                field {
                    desc = "This is a dummy r/w field, generated just to show the register in specs";
                    sw = rw;
                } DUMMY[7:0];
        } TouchYHigh @ 0x2;
        reg {
            name="TouchYLow";
            desc = "Could not determine register's width, guessed 8 bits.";
            regwidth=0x8;
                field {
                    desc = "This is a dummy r/w field, generated just to show the register in specs";
                    sw = rw;
                } DUMMY[7:0];
        } TouchYLow @ 0x3;
        reg {
            name="TouchWeight";
            desc = "Could not determine register's width, guessed 8 bits.";
            regwidth=0x8;
                field {
                    desc = "This is a dummy r/w field, generated just to show the register in specs";
                    sw = rw;
                } DUMMY[7:0];
        } TouchWeight @ 0x4;
        reg {
            name="TouchMisc";
            desc = "Could not determine register's width, guessed 8 bits.";
            regwidth=0x8;
                field {
                    desc = "This is a dummy r/w field, generated just to show the register in specs";
                    sw = rw;
                } DUMMY[7:0];
        } TouchMisc @ 0x5;
    } TouchDataRegisters_addrmap;

    addrmap {
        desc = "Generated by RenodeModelsAnalyzer";
        reg {
            name="GestureId";
            desc = "Could not determine register's width, guessed 8 bits.";
            regwidth=0x8;
                field {
                    desc = "This is a dummy r/w field, generated just to show the register in specs";
                    sw = rw;
                } DUMMY[7:0];
        } GestureId @ 0x1;
        reg {
            name="TouchDataStatus";
            desc = "Could not determine register's width, guessed 8 bits.";
            regwidth=0x8;
                field {
                    desc = "This is a dummy r/w field, generated just to show the register in specs";
                    sw = rw;
                } DUMMY[7:0];
        } TouchDataStatus @ 0x2;
        reg {
            name="TouchBeginRegister";
            desc = "Could not determine register's width, guessed 8 bits.";
            regwidth=0x8;
                field {
                    desc = "This is a dummy r/w field, generated just to show the register in specs";
                    sw = rw;
                } DUMMY[7:0];
        } TouchBeginRegister @ 0x3;
        reg {
            name="TouchEndRegister";
            desc = "Could not determine register's width, guessed 8 bits.";
            regwidth=0x8;
                field {
                    desc = "This is a dummy r/w field, generated just to show the register in specs";
                    sw = rw;
                } DUMMY[7:0];
        } TouchEndRegister @ 0x21;
        reg {
            name="InterruptStatus";
            desc = "Could not determine register's width, guessed 8 bits.";
            regwidth=0x8;
                field {
                    desc = "This is a dummy r/w field, generated just to show the register in specs";
                    sw = rw;
                } DUMMY[7:0];
        } InterruptStatus @ 0xa4;
        reg {
            name="ChipVendorId";
            desc = "Could not determine register's width, guessed 8 bits.";
            regwidth=-8 + 4 * 4;
                field {
                    desc = "This is a dummy r/w field, generated just to show the register in specs";
                    sw = rw;
                } DUMMY[7:0];
        } ChipVendorId @ 0xa8;
    } Registers_addrmap;


};